.TITLE Controller Plug
V_Rail_0 vcc 0 DC 5.0
.END
