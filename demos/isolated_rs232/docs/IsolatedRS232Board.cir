.TITLE Isolated RS-232
U1 nc_0 nc_1 net_2 nc_2 nc_3 net_3 nc_4 nc_5 nc_6 nc_7 net_12 nc_8 nc_9 net_11 nc_10 nc_11 ISOW7841
U2 nc_12 nc_13 nc_14 nc_15 nc_16 nc_17 nc_18 nc_19 nc_20 nc_21 nc_22 nc_23 nc_24 nc_25 net_11 net_12 net_1 net_0 nc_26 nc_27 TRS3122E
C1 net_10 net_10 1e-07
C2 net_9 net_9 1e-05
C3 net_8 net_8 1e-07
C4 net_7 net_7 1e-07
C5 net_6 net_6 1e-07
C6 net_5 net_5 1e-07
C7 net_4 net_4 1e-07
.LIB spice-models.lib
.END
