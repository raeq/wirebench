.TITLE Sensor Board
U1 net_0 net_1 nc_0 nc_1 nc_2 nc_3 nc_4 nc_5 nc_6 nc_7 nc_8 nc_9 net_3 net_2 ULN2003A
.LIB spice-models.lib
.END
