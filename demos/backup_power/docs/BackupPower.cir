.TITLE BackupPower
V_Rail_0 nc_0 0 DC 5.0
U1 nc_1 nc_2 nc_3 nc_4 nc_5 nc_6 nc_7 nc_8 nc_9 nc_10 TPS2660
U2 nc_11 nc_12 nc_13 nc_14 nc_15 nc_16 nc_17 nc_18 LM5002
U3 nc_19 nc_20 nc_21 nc_22 nc_23 nc_24 nc_25 nc_26 nc_27 nc_28 nc_29 nc_30 nc_31 nc_32 nc_33 nc_34 LM5160
L1 nc_35 nc_36 3.3e-05
D1 nc_37 nc_38 D1N5817
C10 nc_39 nc_40 0.0012
C1 nc_41 nc_42 1e-08
C2 nc_43 nc_44 1e-06
C3 nc_45 nc_46 1e-06
C4 nc_47 nc_48 3.3e-09
C5 nc_49 nc_50 2.2e-08
C6 nc_51 nc_52 1e-06
C7 nc_53 nc_54 1e-07
C8 nc_55 nc_56 1e-06
C9 nc_57 nc_58 1e-07
C12 nc_59 nc_60 1e-06
C13 nc_61 nc_62 0.00022
C14 nc_63 nc_64 1e-06
C15 nc_65 nc_66 2.2e-06
R6 nc_67 nc_68 715000.0
R7 nc_69 nc_70 226000.0
R11 nc_71 nc_72 40200.0
R16 nc_73 nc_74 10000.0
.LIB spice-models.lib
.END
