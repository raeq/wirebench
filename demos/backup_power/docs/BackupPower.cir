.TITLE BackupPower
V_Rail_0 vcc 0 DC 5.0
U1 nc_0 nc_1 nc_2 nc_3 nc_4 nc_5 nc_6 nc_7 nc_8 nc_9 TPS2660
U2 nc_10 nc_11 nc_12 nc_13 nc_14 nc_15 nc_16 nc_17 LM5002
U3 nc_18 nc_19 nc_20 nc_21 nc_22 nc_23 nc_24 nc_25 nc_26 nc_27 nc_28 nc_29 nc_30 nc_31 nc_32 nc_33 LM5160
L1 vcc vcc 3.3e-05
D1 vcc vcc D1N5817
C10 vcc vcc 0.0012
C1 vcc vcc 1e-08
C2 vcc vcc 1e-06
C3 vcc vcc 1e-06
C4 vcc vcc 3.3e-09
C5 vcc vcc 2.2e-08
C6 vcc vcc 1e-06
C7 vcc vcc 1e-07
C8 vcc vcc 1e-06
C9 vcc vcc 1e-07
C12 vcc vcc 1e-06
C13 vcc vcc 0.00022
C14 vcc vcc 1e-06
C15 vcc vcc 2.2e-06
R6 vcc vcc 715000.0
R7 vcc vcc 226000.0
R11 vcc vcc 40200.0
R16 vcc vcc 10000.0
.LIB spice-models.lib
.END
