.TITLE DigitalThermometer
U1 nc_0 nc_1 nc_2 net_14 net_3 net_11 nc_3 nc_4 nc_5 nc_6 net_10 net_13 net_9 net_7 net_5 net_4 net_12 net_8 net_6 nc_7 nc_8 nc_9 nc_10 nc_11 nc_12 nc_13 nc_14 nc_15 Uno_ThermometerSketch
U2 vcc net_14 0 DHT11_Module
U3 net_4 net_5 net_6 net_7 net_8 0 net_9 net_10 net_11 net_12 net_13 net_3 Display5641AS
R1 net_3 net_3 220.0
V_Rail_0 vcc 0 DC 5.0
.LIB spice-models.lib
.END
