.TITLE BLDC Controller
U1 nc_0 nc_1 nc_2 net_14 net_15 net_17 nc_3 nc_4 nc_5 nc_6 net_18 net_20 net_21 net_13 net_16 net_19 nc_7 nc_8 nc_9 nc_10 nc_11 nc_12 net_0 net_1 net_2 nc_13 nc_14 nc_15 Uno_BLDCCommutator
U2 nc_16 nc_17 nc_18 nc_19 nc_20 nc_21 nc_22 nc_23 nc_24 nc_25 net_13 net_14 net_15 net_16 net_17 net_18 net_19 net_20 net_21 nc_26 net_3 nc_27 net_4 nc_28 net_5 nc_29 nc_30 nc_31 DRV8313
C1 net_12 net_12 1e-08
C2 net_11 net_11 1e-08
C3 net_10 net_10 1e-08
C4 net_9 net_9 1e-08
C5 net_8 net_8 1e-07
C6 net_7 net_7 1e-05
R1 net_6 net_6 10000.0
.LIB spice-models.lib
.END
