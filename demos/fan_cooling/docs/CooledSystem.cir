.TITLE CooledSystem
XA1 vcc 0 A1_SUBCKT
.SUBCKT A1_SUBCKT vcc 0
V_Rail_0 vcc 0 DC 5.0
.ENDS A1_SUBCKT
XA2 vcc 0 nc_0 nc_1 A2_SUBCKT
.SUBCKT A2_SUBCKT vcc 0 nc_0 nc_1
U1 nc_2 nc_3 nc_4 nc_5 nc_6 nc_7 TMP302
U2 nc_8 nc_9 nc_10 nc_11 nc_12 SN74AHC1G14
M1 nc_13 nc_14 nc_15 Q2N7000
D1 net_6 net_6 D1N4728A
R1 net_5 net_5 10000.0
R2 net_4 net_4 10000.0
R3 net_3 net_3 10000.0
.ENDS A2_SUBCKT
.LIB spice-models.lib
.END
