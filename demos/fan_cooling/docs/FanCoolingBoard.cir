.TITLE Fan Cooling Module
U1 nc_0 nc_1 nc_2 nc_3 nc_4 nc_5 TMP302
U2 nc_6 nc_7 nc_8 nc_9 nc_10 SN74AHC1G14
M1 nc_11 nc_12 nc_13 Q2N7000
D1 net_5 net_5 D1N4728A
R1 net_4 net_4 10000.0
R2 net_3 net_3 10000.0
R3 net_2 net_2 10000.0
.LIB spice-models.lib
.END
