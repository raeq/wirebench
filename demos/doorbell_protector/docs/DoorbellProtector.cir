.TITLE DoorbellProtector
V_Rail_0 vcc 0 DC 5.0
V_Rail_1 vcc 0 DC 5.0
U1 0 nc_0 net_0 net_3 nc_1 nc_2 nc_3 vcc NE555_Monostable
U2 0 net_0 net_4 vcc nc_4 nc_5 nc_6 vcc NE555_Monostable
Q1 net_1 net_0 0 BC548
Q2 net_3 net_4 0 Q2N3904
D1 net_1 vcc D1N4007
D2 net_0 0 D_LED
R1 net_0 net_0 1000.0
R2 vcc vcc 1000000.0
R3 vcc vcc 1000000.0
R4 net_4 net_4 1000.0
R5 net_3 net_3 10000.0
R6 vcc vcc 1000000.0
R7 vcc vcc 4700.0
R8 vcc vcc 47000.0
C1 vcc vcc 1e-07
C2 vcc vcc 4.7e-06
C3 vcc vcc 1e-07
C4 net_0 net_0 1e-07
C5 vcc vcc 4.7e-05
X1 net_0 net_1 nc_7 nc_8 nc_9 Relay_SPDT
.LIB spice-models.lib
.END
